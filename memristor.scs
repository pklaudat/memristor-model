simulator lang=spectre

*********************************************************************************************
*							SUBCKT MEMRISTOR										*
*********************************************************************************************
parameters Ron=5e3 Roff=30e3 Rinit=5e3 alpha=0 beta=1e18 It=25e-6 C1=0.1 C2=0

real f1(real y, real vx) {
	return (((Roff-vx)/Roff + C1)*beta*y + ((Roff-vx)/Roff + C1)*0.5*(alpha-beta)*(abs(y+It)-abs(y-It)))

}
real f2(real y, real vx) {
	return (((Roff-vx)/Roff + C1)*beta*y + ((Roff-vx)/Roff + C1)*0.5*(alpha-beta)*(abs(y+It)-abs(y-It)))
}

subckt memristor (plus vref)
	Cx x vref capacitor c=1 ic=Rinit
	Bx vref x bsource i=((v(Im,vref) > 0) && (v(x,vref) < Roff)) ? f1(v(Im,vref),v(x,vref)) : ((((v(Im,vref) < 0) && (v(x,vref) > Ron)) ? f2(v(Im,vref),v(x,vref)) : 0))
	ImSource Im vref bsource v=(v(plus,vref)/v(x,vref))
	Rmem plus vref bsource r=v(x,vref)
ends memristor
