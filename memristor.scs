simulator lang=spectre

*********************************************************************************************
*							SUBCKT MEMRISTOR										*
*********************************************************************************************
parameters Ron=5e3 Roff=30e3 Rinit=5e3 alpha=0 beta=1e18 It=25e-6 C1=0.1 C2=0

real f1(real y, real vx) {
	return (((Roff-vx)/Roff + C1)*beta*y + ((Roff-vx)/Roff + C1)*0.5*(alpha-beta)*(abs(y+It)-abs(y-It)))

}
real f2(real y, real vx) {
	return (((Roff-vx)/Roff + C1)*beta*y + ((Roff-vx)/Roff + C1)*0.5*(alpha-beta)*(abs(y+It)-abs(y-It)))
}

subckt memristor (node gnd)
	Baux1 Im gnd bsource v=(v(plus,minus)/v(x,gnd))
	Bx gnd x bsource i=((v(Im,gnd)> 0) && (v(x) < Roff)) ? f1(v(Im,gnd),v(x,gnd)) : ((((v(Im,gnd) < 0) && (v(x,gnd)>Ron)) ? f2(v(Im,gnd),v(x,gnd)) : 0))
	Rmem plus minus bsource r=v(x,gnd)
	Cx x gnd capacitor c=1 ic=Rinit

ends memristor
